OP level 1 case 02: loaded resistor ladder
* Stress-mesh topology family adapted from ngspice manual RC/transmission-line examples; primitive-only subset: https://ngspice.sourceforge.io/docs/ngspice-manual.pdf
VDRV in 0 DC 2.5
RCORE1 in out 1.2k
RCORE2 out 0 2.7k
RF001 out n002 180
RG001 n002 0 13k
RB001 n002 in 5k
RB002 n002 in 8k
RX001 n002 in 22k
RX002 n002 in 23k
.op
.print op v(in) v(out) i(VDRV)
.end
