SpiceFuzz generated DC operating-point netlist
.model NPNMOD NPN IS=1e-16 BF=120 BR=2 NF=1 NR=1 GMIN=1e-10
.model PMOSMOD PMOS LEVEL=1 VTO=-1.2 KP=2e-5 GAMMA=0.5 PHI=0.7 LAMBDA=0.02
.model NMOSMOD NMOS LEVEL=1 VTO=0.9 KP=4e-5 GAMMA=0.5 PHI=0.7 LAMBDA=0.02
VCC vcc 0 DC 5
VEE vee 0 DC -3
VINP inp 0 DC 0.02
VINN inn 0 DC 0
QCORE1 out inp tail NPNMOD
QCORE2 qc2 inn tail NPNMOD AREA=1.1
RCORE1 vcc out 3.9k
RCORE2 vcc qc2 3.9k
RTAIL tail vee 1.8k
ROUT out 0 220k
RF001 tail n004 180
RG001 n004 0 13k
RB001 n004 qc2 5k
RB002 n004 vcc 8k
RX001 n004 vcc 22k
RX002 n004 vcc 23k
RX003 n004 vcc 24k
QF001 n004 0 0 NPNMOD AREA=1
RF002 n004 n005 316
RG002 n005 0 21k
RB003 n005 tail 13k
RB004 n005 out 16k
RX004 n005 vcc 30k
RX005 n005 vcc 31k
RX006 n005 vcc 32k
QF002 n005 0 0 NPNMOD AREA=1
RF003 n005 n006 452
RG003 n006 0 29k
M1 out qc2 vcc vcc PMOSMOD W=20u L=2u
M2 qc2 out vcc vcc PMOSMOD W=20u L=2u
M3 out qc2 vee vee NMOSMOD W=10u L=2u
M4 qc2 out vee vee NMOSMOD W=10u L=2u
RDCP1 out 0 470k
RDCP2 qc2 0 470k
.op
.print op v(vcc) v(out) v(qc2) v(tail) i(VCC)
.end
