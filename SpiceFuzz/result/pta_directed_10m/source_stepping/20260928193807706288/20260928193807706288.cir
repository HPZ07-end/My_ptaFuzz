SpiceFuzz generated DC operating-point netlist
.model DMOD D IS=2e-14 N=1.03 GMIN=1e-10
.model QNPN NPN IS=1e-15 BF=120 VAF=80
.model QPNP PNP IS=4e-15 BF=80 BR=2 NF=1.02 NR=1.05 VAF=60 IKF=1e-3
VDRV in 0 DC 1.8
RCORE1 in out 820
DCORE1 out 0 DMOD
DCORE2 0 out DMOD AREA=1.5
RCORE2 out 0 47k
RF001 out n002 180
RG001 n002 0 130k
RB001 n002 in 5k
RB002 n002 in 8k
RX001 n002 in 22k
DF001 0 n002 DMOD AREA=3
RX002 n002 in 24k
RX003 n002 in 25k
RF002 n002 n003 316
RG002 n003 0 210k
RB003 n003 out 13k
RB004 n003 in 16k
RX004 n003 in 30k
DF002 0 n003 DMOD AREA=2
RX005 n003 in 32k
RX006 n003 in 33k
RF003 n003 n004 452
Q1 n003 n002 emit QNPN
Q2 n002 n003 emit QNPN
Q3 n004 n002 emit QPNP AREA=1.2
RE1 emit 0 12k
RC1 n003 in 10k
RC2 n002 in 10k
.op
.print op v(in) v(out) v(n002) v(n003) v(n004) v(emit) i(VDRV)
.end
