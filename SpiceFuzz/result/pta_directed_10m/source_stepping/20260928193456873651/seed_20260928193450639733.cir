SpiceFuzz generated DC operating-point netlist
VDRV in 0 DC 2.5
RCORE1 in out 1.2k
RCORE2 out 0 2.7k
CCORE out 0 12n
RF001 out n002 180
RG001 n002 0 13k
CF001 n002 0 4n
RB001 n002 in 8k
Q001 n002 n002 0 QMOD
Q002 n003 n003 n002 QMOD
Q003 n004 n004 n003 QMOD
Q004 n005 n005 n004 QMOD
Q005 n006 n006 n005 QMOD
RF002 n002 n003 316
RG002 n003 0 21k
CF002 n003 0 12n
RB002 n003 in 16k
RF003 n003 n004 452
RG003 n004 0 29k
CF003 n004 0 7n
RB003 n004 in 7k
RF004 n004 n005 265
RG004 n005 0 14k
CF004 n005 0 2n
RB004 n005 out 15k
RF005 n005 n006 401
RG005 n006 0 22k
CF005 n006 0 10n
RB005 n006 n002 6k
.model QMOD NPN (IS=1e-15 BF=100 VAF=100)
.op
.print op v(in) v(out) i(VDRV)
.end
