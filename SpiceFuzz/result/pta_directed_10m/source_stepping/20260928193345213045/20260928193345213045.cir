SpiceFuzz generated DC operating-point netlist
.model DMOD D IS=2e-14 N=1.03 GMIN=1e-10
VDRV in 0 DC 1.8
VBIAS n009 0 DC 0.6
RCORE1 in out 820
DCORE1 out 0 DMOD
DCORE2 0 out DMOD AREA=1.5
RCORE2 out 0 4.7k
RF001 out n002 18
RG001 n002 0 1.3Meg
RB001 n002 out 5k
RB002 n002 in 8k
RX001 n002 in 220k
DF001 0 n002 DMOD AREA=3
RX002 n002 in 2.4k
RX003 n002 in 25k
RF002 n002 n003 31.6k
RG002 n003 0 21
RB003 n003 out 13k
RB004 n003 in 1.6Meg
RX004 n003 in 30k
DF002 0 n003 DMOD AREA=2
RX005 n003 in 320k
RX006 n003 in 33k
RF003 n003 n004 45.2
RG003 n004 0 290k
RB005 n004 n002 10k
RB006 n004 in 7k
RX007 n004 in 3.8Meg
DF003 0 n004 DMOD AREA=1
RX008 n004 in 40k
RX009 n004 in 4.1k
RF004 n004 n005 26.5k
RG004 n005 0 14k
RB007 n005 n003 700
RB008 n005 out 15k
RX010 n005 in 46k
DF004 0 n005 DMOD AREA=3
RX011 n005 in 190k
RX012 n005 in 20k
RF005 n005 n006 40.1
RG005 n006 0 2.2Meg
RB009 n006 n004 4k
RB010 n006 n002 6k
RX013 n006 in 25k
DF005 0 n006 DMOD AREA=2
RX014 n006 in 270k
RX015 n006 in 28k
RF006 n006 n007 21.4k
RG006 n007 0 30k
RB011 n007 n005 1.2Meg
RB012 n007 n003 14k
RX016 n007 in 33k
DF006 0 n007 DMOD AREA=1
RX017 n007 in 3.5k
RX018 n007 in 36k
RF007 n007 n008 35k
RG007 n008 0 150k
RB013 n008 n006 9k
RB014 n008 n004 5k
RX019 n008 in 410k
DF007 0 n008 DMOD AREA=3
RX020 n008 in 43k
RX021 n008 in 4.4Meg
RF008 n008 n009 48.6
RG008 n009 0 230k
RB015 n009 n007 6k
RB016 n009 n005 1.3Meg
RX022 n009 in 20k
RB017 n002 out 3.3k
.op
.print op v(in) v(out) i(VDRV)
.end
