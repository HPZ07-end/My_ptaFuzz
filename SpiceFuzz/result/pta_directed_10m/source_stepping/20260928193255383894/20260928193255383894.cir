SpiceFuzz generated DC operating-point netlist
VDRV in 0 DC 2.5
RCORE1 in lmid 68
LCORE lmid out 120u
CCORE out 0 22n
RCORE2 out 0 1.8k
RF001 out n003 180
RG001 n003 0 13k
CF001 n003 0 4n
RB001 n003 in 8k
LF001 n003 l004 50u
RX001 l004 in 23k
RX002 l004 in 24k
RX003 l004 in 25k
RF002 l004 n005 316
Q1 n005 n003 0 QNPNMOD
Q2 n005 n006 0 QNPNMOD
RB2 n006 n003 47k
RC2 n005 0 2.2k
RBIAS n006 0 1Meg
VBIAS n006 0 DC 0.6
RBIAS2 n006 n007 1Meg
VBIAS2 n007 0 DC 0.58
RBIAS3 n006 n008 1Meg
VBIAS3 n008 0 DC 0.62
.nodeset v(n005)=0.65 v(n006)=0.6 v(n007)=0.58 v(n008)=0.62
.model QNPNMOD NPN (IS=1e-15 BF=120 VAF=80)
.op
.print op v(in) v(out) v(lmid) v(n003) v(n005) v(n006) v(n007) v(n008) i(VDRV) i(LCORE)
.end
