OP level 4 case 16: cmos nand stress backplane
* Stress-mesh topology family adapted from ngspice manual differential-pair and four-bit NAND-adder examples; primitive-only subset: https://ngspice.sourceforge.io/docs/ngspice-manual.pdf
.model NMOD NMOS LEVEL=1 VTO=0.7 KP=80u LAMBDA=0.02 GMIN=1e-10
.model PMOD PMOS LEVEL=1 VTO=-0.7 KP=40u LAMBDA=0.02 GMIN=1e-10
VDD vdd 0 DC 5
VA a 0 DC 0.4
VB b 0 DC 2.7
MCOREP1 out a vdd vdd PMOD W=20u L=1u
MCOREP2 out b vdd vdd PMOD W=20u L=1u
MCOREN1 out a stack 0 NMOD W=12u L=1u
MCOREN2 stack b 0 0 NMOD W=12u L=1u
RSTACK stack 0 1meg
ROUT out 0 220k
RF001 out n005 180
RG001 n005 0 13k
RB001 n005 stack 5k
RB002 n005 a 8k
RX001 n005 vdd 22k
RX002 n005 vdd 23k
MF001 n005 0 0 0 NMOD W=8u L=1u
RX003 n005 vdd 25k
RF002 n005 n006 316
RG002 n006 0 21k
RB003 n006 out 13k
RB004 n006 b 16k
RX004 n006 vdd 30k
RX005 n006 vdd 31k
MF002 n006 0 0 0 NMOD W=8u L=1u
RX006 n006 vdd 33k
RF003 n006 n007 452
RG003 n007 0 29k
RB005 n007 n005 10k
RB006 n007 stack 7k
RX007 n007 vdd 38k
RX008 n007 vdd 39k
MF003 n007 0 0 0 NMOD W=8u L=1u
RX009 n007 vdd 41k
RF004 n007 n008 265
RG004 n008 0 14k
RB007 n008 n006 7k
RB008 n008 out 15k
RX010 n008 vdd 46k
RX011 n008 vdd 18k
MF004 n008 0 0 0 NMOD W=8u L=1u
RX012 n008 vdd 20k
RF005 n008 n009 401
RG005 n009 0 22k
RB009 n009 n007 4k
RB010 n009 n005 6k
RX013 n009 vdd 25k
RX014 n009 vdd 26k
MF005 n009 0 0 0 NMOD W=8u L=1u
RX015 n009 vdd 28k
RF006 n009 n010 214
RG006 n010 0 30k
RB011 n010 n008 12k
RB012 n010 n006 14k
RX016 n010 vdd 33k
RX017 n010 vdd 34k
MF006 n010 0 0 0 NMOD W=8u L=1u
RX018 n010 vdd 36k
RF007 n010 n011 350
RG007 n011 0 15k
RB013 n011 n009 9k
RB014 n011 n007 5k
RX019 n011 vdd 41k
RX020 n011 vdd 42k
MF007 n011 0 0 0 NMOD W=8u L=1u
RX021 n011 vdd 44k
RF008 n011 n012 486
RG008 n012 0 23k
RB015 n012 n010 6k
RB016 n012 n008 13k
RX022 n012 vdd 20k
RX023 n012 vdd 21k
MF008 n012 0 0 0 NMOD W=8u L=1u
RX024 n012 vdd 23k
RF009 n012 n013 299
RG009 n013 0 31k
RB017 n013 n011 3k
RB018 n013 n009 21k
RX025 n013 vdd 28k
RX026 n013 vdd 29k
MF009 n013 0 0 0 NMOD W=8u L=1u
RX027 n013 vdd 31k
RF010 n013 n014 435
RG010 n014 0 16k
RB019 n014 n012 11k
RB020 n014 n010 12k
RX028 n014 vdd 36k
RX029 n014 vdd 37k
MF010 n014 0 0 0 NMOD W=8u L=1u
RX030 n014 vdd 39k
RF011 n014 n015 248
RG011 n015 0 24k
RB021 n015 n013 8k
RB022 n015 n011 20k
RX031 n015 vdd 44k
RX032 n015 vdd 45k
MF011 n015 0 0 0 NMOD W=8u L=1u
RX033 n015 vdd 18k
RF012 n015 n016 384
RG012 n016 0 32k
RB023 n016 n014 5k
RB024 n016 n012 11k
RX034 n016 vdd 23k
RX035 n016 vdd 24k
MF012 n016 0 0 0 NMOD W=8u L=1u
RX036 n016 vdd 26k
RF013 n016 n017 197
RG013 n017 0 17k
RB025 n017 n015 13k
RB026 n017 n013 19k
RX037 n017 vdd 31k
RX038 n017 vdd 32k
MF013 n017 0 0 0 NMOD W=8u L=1u
RX039 n017 vdd 34k
RF014 n017 n018 333
RG014 n018 0 25k
RB027 n018 n016 10k
RB028 n018 n014 10k
RX040 n018 vdd 39k
RX041 n018 vdd 40k
MF014 n018 0 0 0 NMOD W=8u L=1u
RX042 n018 vdd 42k
RF015 n018 n019 469
RG015 n019 0 33k
RB029 n019 n017 7k
RB030 n019 n015 18k
RX043 n019 vdd 18k
RX044 n019 vdd 19k
MF015 n019 0 0 0 NMOD W=8u L=1u
RX045 n019 vdd 21k
RF016 n019 n020 282
RG016 n020 0 18k
RB031 n020 n018 4k
RB032 n020 n016 9k
RX046 n020 vdd 26k
RX047 n020 vdd 27k
MF016 n020 0 0 0 NMOD W=8u L=1u
RX048 n020 vdd 29k
RF017 n020 n021 418
RG017 n021 0 26k
RB033 n021 n019 12k
RB034 n021 n017 17k
RX049 n021 vdd 34k
RX050 n021 vdd 35k
MF017 n021 0 0 0 NMOD W=8u L=1u
RX051 n021 vdd 37k
RF018 n021 n022 231
RG018 n022 0 34k
RB035 n022 n020 9k
RB036 n022 n018 8k
RX052 n022 vdd 42k
RX053 n022 vdd 43k
MF018 n022 0 0 0 NMOD W=8u L=1u
RX054 n022 vdd 45k
RF019 n022 n023 367
RG019 n023 0 19k
RB037 n023 n021 6k
RB038 n023 n019 16k
RX055 n023 vdd 21k
RX056 n023 vdd 22k
MF019 n023 0 0 0 NMOD W=8u L=1u
RX057 n023 vdd 24k
RF020 n023 n024 180
RG020 n024 0 27k
RB039 n024 n022 3k
RB040 n024 n020 7k
RX058 n024 vdd 29k
RX059 n024 vdd 30k
MF020 n024 0 0 0 NMOD W=8u L=1u
RX060 n024 vdd 32k
RF021 n024 n025 316
RG021 n025 0 12k
RB041 n025 n023 11k
RB042 n025 n021 15k
RX061 n025 vdd 37k
RX062 n025 vdd 38k
MF021 n025 0 0 0 NMOD W=8u L=1u
RX063 n025 vdd 40k
RF022 n025 n026 452
RG022 n026 0 20k
RB043 n026 n024 8k
RB044 n026 n022 6k
RX064 n026 vdd 45k
RX065 n026 vdd 46k
.op
.print op v(vdd) v(out) v(a) v(stack) i(VDD)
.end
