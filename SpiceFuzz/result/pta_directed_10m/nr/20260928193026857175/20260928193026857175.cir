SpiceFuzz generated DC operating-point netlist
VDRV in 0 DC 2.5
RCORE1 in out 1.2k
RCORE2 out 0 2.7k
RF001 out n002 180
RG001 n002 0 13k
RB001 n002 in 5k
RB002 n002 in 8k
M1 n003 n002 0 0 NMOS W=10u L=1u
M2 n002 n003 0 0 NMOS W=10u L=1u
RD1 vdd n003 4.7k
RD2 vdd n002 4.7k
RS1 n002 0 1meg
RS2 n003 0 1.1meg
VDD vdd 0 DC 3.3
.model NMOS NMOS (LEVEL=1 VTO=0.7 KP=120u LAMBDA=0.02)
.op
.print op v(in) v(out) v(n002) v(n003) i(VDRV)
.end
