SpiceFuzz generated DC operating-point netlist
VDRV in 0 DC 2.5
RCORE1 in out 1.2k
RCORE2 out 0 2.7k
RF001 out n002 180
RG001 n002 0 13k
RB001 n002 in 5k
RB002 n002 in 8k
QPOS out n002 in QGEN
.model QGEN NPN (IS=1e-15 BF=180 VAF=90)
.op
.print op v(in) v(out) v(n002) i(VDRV)
.end
