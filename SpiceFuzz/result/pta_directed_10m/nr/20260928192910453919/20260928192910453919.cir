SpiceFuzz generated DC operating-point netlist
.model NMOD NMOS LEVEL=1 VTO=0.7 KP=80u LAMBDA=0.02 GMIN=1e-10
.model PMOD PMOS LEVEL=1 VTO=-0.7 KP=40u LAMBDA=0.02 GMIN=1e-10
VDD vdd 0 DC 5
VA a 0 DC 0.4
VB b 0 DC 2.7
MCOREP1 out a vdd vdd PMOD W=20u L=1u
MCOREP2 out b vdd vdd PMOD W=20u L=1u
MCOREN1 out a stack 0 NMOD W=12u L=1u
MCOREN2 stack b 0 0 NMOD W=12u L=1u
RSTACK stack 0 1meg
ROUT out 0 220k
RF001 out n005 180
RG001 n005 0 13k
RB001 n005 stack 5k
RB002 n005 a 8k
RX001 n005 vdd 22k
RX002 n005 vdd 23k
MF001 n005 0 0 0 NMOD W=8u L=1u
RX003 n005 vdd 25k
RF002 n005 n006 316
RG002 n006 0 21k
RB003 n006 out 13k
RB004 n006 b 16k
RX004 n006 vdd 30k
RX005 n006 vdd 31k
MF002 n006 0 0 0 NMOD W=8u L=1u
RX006 n006 vdd 33k
RF003 n006 n007 452
RG003 n007 0 29k
RB005 n007 n005 10k
RB006 n007 stack 7k
RX007 n007 vdd 38k
RX008 n007 vdd 39k
MF003 n007 0 0 0 NMOD W=8u L=1u
MF004 out n005 0 0 NMOD W=6u L=1u
MF005 out n006 0 0 NMOD W=6u L=1u
MF006 out n007 0 0 NMOD W=6u L=1u
MG004 out n005 vdd vdd PMOD W=4u L=1u
MG005 out n006 vdd vdd PMOD W=4u L=1u
MG006 out n007 vdd vdd PMOD W=4u L=1u
RFOUT1 out n005 470
RFOUT2 out n006 510
RFOUT3 out n007 560
.op
.print op v(vdd) v(out) v(a) v(stack) i(VDD)
.end
