SpiceFuzz generated DC operating-point netlist
VDRV in 0 DC 2.5
RCORE1 in out 1.2k
RCORE2 out 0 2.7k
RF001 out n002 180
RG001 n002 0 13k
RB001 n002 in 5k
RB002 n002 in 8k
MP001 out n002 in 0 PMOS1 L=2u W=20u
.model PMOS1 PMOS LEVEL=1 VTO=-1.2 KP=80u
.op
.print op v(in) v(out) v(n002) i(VDRV)
.end
