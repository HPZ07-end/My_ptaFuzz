SpiceFuzz generated DC operating-point netlist
.model DMOD D IS=2e-14 N=1.03 GMIN=1e-10
.model PMOD PMOS LEVEL=1 VTO=-0.4 KP=2e-5 LAMBDA=0.02
.model QNPN NPN IS=5e-15 BF=180 VAF=80
VDRV in 0 DC 1.8
RCORE1 in out 820
DCORE1 out 0 DMOD
DCORE2 0 out DMOD AREA=1.5
RCORE2 out 0 4.7k
RF001 out n002 180
RG001 n002 0 13k
RB001 n002 in 5k
RB002 n002 in 8k
RX001 n002 in 22k
DF001 0 n002 DMOD AREA=3
RX002 n002 in 24k
RX003 n002 in 25k
RF002 n002 n003 316
RG002 n003 0 21k
RB003 n003 out 13k
RB004 n003 in 16k
RX004 n003 in 30k
DF002 0 n003 DMOD AREA=2
RX005 n003 in 32k
RX006 n003 in 33k
RF003 n003 n004 452
MP001 n004 n003 in in PMOD L=2u W=20u
RF004 n003 n005 452
MP002 n005 n003 in in PMOD L=2u W=20u
C001 n004 n005 1p
Q001 n004 n005 0 QNPN
Q002 n005 n004 0 QNPN
RC001 in n004 2.2k
RC002 in n005 2.7k
RE001 0 n004 470
RE002 0 n005 390
.op
.print op v(in) v(out) i(VDRV)
.end
