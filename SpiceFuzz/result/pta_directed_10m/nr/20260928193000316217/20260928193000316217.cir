SpiceFuzz generated DC operating-point netlist
.model DMOD D IS=2e-14 N=1.04 GMIN=1e-10
.model NPNMOD NPN IS=1e-16 BF=100 BR=2 GMIN=1e-10
.model NMOD NMOS LEVEL=1 VTO=0.7 KP=70u LAMBDA=0.015 GMIN=1e-10
.model PMOD PMOS LEVEL=1 VTO=-0.7 KP=35u LAMBDA=0.015 GMIN=1e-10
VDD vdd 0 DC 5
VBIAS bias 0 DC 0.62
VIN in 0 DC 1.7
RFEED vdd rail 470k
LFEED rail supply 80u
MPASS out in supply supply PMOD W=24u L=1u
MNLOAD out bias 0 0 NMOD W=10u L=1u
QMON sense bias 0 NPNMOD
DCLAMP sense 0 DMOD
RSENSE out sense 22k
ROUT out 0 1meg
COUT out 0 33n
RF001 sense n005 1.8meg
RG001 n005 0 130k
CF001 n005 0 4n
RB001 n005 rail 80k
LF001 n005 l006 50u
DF001 0 l006 DMOD AREA=3
MF001 l006 0 0 0 NMOD W=8u L=1u
RX001 l006 supply 250k
RF002 l006 n007 3.16meg
RG002 n007 0 210k
CF002 n007 0 12n
RB002 n007 out 160k
LF002 n007 l008 90u
DF002 0 l008 DMOD AREA=2
MF002 l008 0 0 0 NMOD W=8u L=1u
RX002 l008 supply 330k
RF003 l008 n009 4.52meg
RG003 n009 0 290k
CF003 n009 0 7n
RB003 n009 n005 70k
LF003 n009 l010 45u
DF003 0 l010 DMOD AREA=1
MF003 l010 0 0 0 NMOD W=8u L=1u
RX003 l010 supply 410k
RF004 l010 n011 2.65meg
RG004 n011 0 140k
CF004 n011 0 2n
RB004 n011 n007 150k
LF004 l011 l012 85u
DF004 0 l012 DMOD AREA=3
MF004 l012 0 0 0 NMOD W=8u L=1u
RX004 l012 supply 200k
RF005 l012 n013 4.01meg
RG005 n013 0 220k
CF005 n013 0 10n
RB005 n013 n009 60k
LF005 n013 l014 40u
DF005 0 l014 DMOD AREA=2
MF005 l014 0 0 0 NMOD W=8u L=1u
RX005 l014 supply 280k
RF006 l014 n015 2.14meg
RG006 n015 0 300k
CF006 n015 0 5n
RB006 n015 n011 140k
LF006 n015 l016 80u
DF006 0 l016 DMOD AREA=1
MF006 l016 0 0 0 NMOD W=8u L=1u
RX006 l016 supply 360k
RF007 l016 n017 3.50meg
RG007 n017 0 150k
CF007 n017 0 13n
RB007 n017 n013 50k
LF007 n017 l018 35u
DF007 0 l018 DMOD AREA=3
MF007 l018 0 0 0 NMOD W=8u L=1u
RX007 l018 supply 440k
RF008 l018 n019 4.86meg
RG008 n019 0 230k
CF008 n019 0 8n
RB008 n019 n015 130k
LF008 n019 l020 75u
DF008 0 l020 DMOD AREA=2
MF008 l020 0 0 0 NMOD W=8u L=1u
RX008 l020 supply 230k
RF009 l020 n021 2.99meg
RG009 n021 0 310k
CF009 n021 0 3n
RB009 n021 n017 210k
LF009 n021 l022 30u
DF009 0 l022 DMOD AREA=1
MF009 l022 0 0 0 NMOD W=8u L=1u
RX009 l022 supply 310k
RF010 l022 n023 4.35meg
RG010 n023 0 160k
CF010 n023 0 11n
RB010 n023 n019 120k
LF010 n023 l024 70u
DF010 0 l024 DMOD AREA=3
MF010 l024 0 0 0 NMOD W=8u L=1u
RX010 l024 supply 390k
RF011 l024 n025 2.48meg
RG011 n025 0 240k
CF011 n025 0 6n
RB011 n025 n021 200k
LF011 n025 l026 110u
DF011 0 l026 DMOD AREA=2
MF011 l026 0 0 0 NMOD W=8u L=1u
RX011 l026 supply 180k
RF012 l026 n027 3.84meg
RG012 n027 0 320k
CF012 n027 0 14n
RB012 n027 n023 110k
LF012 n027 l028 65u
DF012 0 l028 DMOD AREA=1
MF012 l028 0 0 0 NMOD W=8u L=1u
RX012 l028 supply 260k
RF013 l028 n029 1.97meg
RG013 n029 0 170k
CF013 n029 0 9n
RB013 n029 n025 190k
LF013 n029 l030 105u
DF013 0 l030 DMOD AREA=3
MF013 l030 0 0 0 NMOD W=8u L=1u
RX013 l030 supply 340k
RF014 l030 n031 3.33meg
RG014 n031 0 250k
CF014 n031 0 4n
RB014 n031 n027 100k
LF014 n031 l032 60u
DF014 0 l032 DMOD AREA=2
MF014 l032 0 0 0 NMOD W=8u L=1u
RX014 l032 supply 420k
RF015 l032 n033 4.69meg
RG015 n033 0 330k
CF015 n033 0 12n
RB015 n033 n029 180k
LF015 n033 l034 100u
DF015 0 l034 DMOD AREA=1
MF015 l034 0 0 0 NMOD W=8u L=1u
RX015 l034 supply 210k
RF016 l034 n035 2.82meg
RG016 n035 0 180k
CF016 n035 0 7n
RB016 n035 n031 90k
LF016 n035 l036 55u
DF016 0 l036 DMOD AREA=3
MF016 l036 0 0 0 NMOD W=8u L=1u
RX016 l036 supply 290k
RF017 l036 n037 4.18meg
RG017 n037 0 260k
CF017 n037 0 2n
RB017 n037 n033 170k
LF017 n037 l038 95u
DF017 0 l038 DMOD AREA=2
MF017 l038 0 0 0 NMOD W=8u L=1u
RX017 l038 supply 370k
RF018 l038 n039 2.31meg
RG018 n039 0 340k
CF018 n039 0 10n
RB018 n039 n035 80k
LF018 n039 l040 50u
DF018 0 l040 DMOD AREA=1
MF018 l040 0 0 0 NMOD W=8u L=1u
RX018 l040 supply 450k
RF019 l040 n041 3.67meg
RG019 n041 0 190k
CF019 n041 0 5n
RB019 n041 n037 160k
LF019 n041 l042 90u
DF019 0 l042 DMOD AREA=3
MF019 l042 0 0 0 NMOD W=8u L=1u
RX019 l042 supply 240k
RF020 l042 n043 1.80meg
RG020 n043 0 270k
CF020 n043 0 13n
RB020 n043 n039 70k
LF020 n043 l044 45u
DF020 0 l044 DMOD AREA=2
MF020 l044 0 0 0 NMOD W=8u L=1u
RX020 l044 supply 320k
RF021 l044 n045 3.16meg
RG021 n045 0 120k
CF021 n045 0 8n
RB021 n045 n041 150k
LF021 n045 l046 85u
DF021 0 l046 DMOD AREA=1
MF021 l046 0 0 0 NMOD W=8u L=1u
RX021 l046 supply 400k
RF022 l046 n047 4.52meg
RG022 n047 0 200k
CF022 n047 0 3n
RB022 n047 n043 60k
LF022 n047 l048 40u
DF022 0 l048 DMOD AREA=3
MF022 l048 0 0 0 NMOD W=8u L=1u
RX022 l048 supply 190k
RF023 l048 n049 2.65meg
RG023 n049 0 280k
CF023 n049 0 11n
RB023 n049 n045 140k
LF023 n049 l050 80u
DF023 0 l050 DMOD AREA=2
MF023 l050 0 0 0 NMOD W=8u L=1u
RX023 l050 supply 270k
RF024 l050 n051 4.01meg
RG024 n051 0 130k
CF024 n051 0 6n
RB024 n051 n047 50k
LF024 n051 l052 35u
DF024 0 l052 DMOD AREA=1
MF024 l052 0 0 0 NMOD W=8u L=1u
RX024 l052 supply 350k
RF025 l052 n053 2.14meg
RG025 n053 0 210k
CF025 n053 0 14n
RB025 n053 n049 130k
LF025 n053 l054 75u
DF025 0 l054 DMOD AREA=3
MF025 l054 0 0 0 NMOD W=8u L=1u
RX025 l054 supply 430k
RF026 l054 n055 3.50meg
RG026 n055 0 290k
CF026 n055 0 9n
RB026 n055 n051 210k
LF026 n055 l056 30u
DF026 0 l056 DMOD AREA=2
MF026 l056 0 0 0 NMOD W=8u L=1u
RX026 l056 supply 220k
RF027 l056 n057 4.86meg
RG027 n057 0 140k
CF027 n057 0 4n
RB027 n057 n053 120k
LF027 n057 l058 70u
DF027 0 l058 DMOD AREA=1
MF027 l058 0 0 0 NMOD W=8u L=1u
RX027 l058 supply 300k
RF028 l058 n059 2.99meg
RG028 n059 0 220k
CF028 n059 0 12n
RB028 n059 n055 200k
LF028 n059 l060 110u
DF028 0 l060 DMOD AREA=3
MF028 l060 0 0 0 NMOD W=8u L=1u
RX028 l060 supply 380k
RF029 l060 n061 4.35meg
RG029 n061 0 300k
CF029 n061 0 7n
RB029 n061 n057 110k
LF029 n061 l062 65u
DF029 0 l062 DMOD AREA=2
MF029 l062 0 0 0 NMOD W=8u L=1u
RX029 l062 supply 460k
RF030 l062 n063 2.48meg
RG030 n063 0 150k
CF030 n063 0 2n
RB030 n063 n059 190k
LF030 n063 l064 105u
DF030 0 l064 DMOD AREA=1
MF030 l064 0 0 0 NMOD W=8u L=1u
RX030 l064 supply 250k
RF031 l064 n065 3.84meg
RG031 n065 0 230k
CF031 n065 0 10n
RB031 n065 n061 100k
LF031 n065 l066 60u
DF031 0 l066 DMOD AREA=3
MF031 l066 0 0 0 NMOD W=8u L=1u
RX031 l066 supply 330k
RF032 l066 n067 1.97meg
RG032 n067 0 310k
CF032 n067 0 5n
RB032 n067 n063 180k
LF032 n067 l068 100u
DF032 0 l068 DMOD AREA=2
MF032 l068 0 0 0 NMOD W=8u L=1u
RX032 l068 supply 410k
RF033 l068 n069 3.33meg
RG033 n069 0 160k
CF033 n069 0 13n
RB033 n069 n065 90k
LF033 n069 l070 55u
DF033 0 l070 DMOD AREA=1
MF033 l070 0 0 0 NMOD W=8u L=1u
RX033 l070 supply 200k
RF034 l070 n071 4.69meg
RG034 n071 0 240k
CF034 n071 0 8n
RB034 n071 n067 170k
LF034 n071 l072 95u
DF034 0 l072 DMOD AREA=3
MF034 l072 0 0 0 NMOD W=8u L=1u
RX034 l072 supply 280k
RF035 l072 n073 2.82meg
RG035 n073 0 320k
CF035 n073 0 3n
RB035 n073 n069 80k
LF035 n073 l074 50u
DF035 0 l074 DMOD AREA=2
MF035 l074 0 0 0 NMOD W=8u L=1u
RX035 l074 supply 360k
RF036 l074 n075 4.18meg
RG036 n075 0 170k
CF036 n075 0 11n
RB036 n075 n071 160k
LF036 n075 l076 90u
DF036 0 l076 DMOD AREA=1
MF036 l076 0 0 0 NMOD W=8u L=1u
RX036 l076 supply 440k
RF037 l076 n077 2.31meg
RG037 n077 0 250k
CF037 n077 0 6n
RB037 n077 n073 70k
LF037 n077 l078 45u
DF037 0 l078 DMOD AREA=3
MF037 l078 0 0 0 NMOD W=8u L=1u
RX037 l078 supply 230k
RF038 l078 n079 3.67meg
RG038 n079 0 330k
CF038 n079 0 14n
RB038 n079 n075 150k
LF038 n079 l080 85u
DF038 0 l080 DMOD AREA=2
MF038 l080 0 0 0 NMOD W=8u L=1u
RX038 l080 supply 310k
RF039 l080 n081 1.80meg
RG039 n081 0 180k
CF039 n081 0 9n
RB039 n081 n077 60k
LF039 n081 l082 40u
DF039 0 l082 DMOD AREA=1
MF039 l082 0 0 0 NMOD W=8u L=1u
RX039 l082 supply 390k
RF040 l082 n083 3.16meg
RG040 n083 0 260k
CF040 n083 0 4n
RB040 n083 n079 140k
LF040 n083 l084 80u
DF040 0 l084 DMOD AREA=3
MF040 l084 0 0 0 NMOD W=8u L=1u
.op
.print op v(supply) v(out) v(rail) v(sense) i(VDD) i(LFEED)
.end
