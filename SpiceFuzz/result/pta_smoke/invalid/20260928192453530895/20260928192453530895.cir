SpiceFuzz generated DC operating-point netlist
.model NMOD NMOS LEVEL=1 VTO=0.7 KP=200u LAMBDA=0.02
.model PMOD PMOS LEVEL=1 VTO=-0.7 KP=100u LAMBDA=0.02
.model DCLAMP D IS=1e-14 N=1.05 RS=10
VDD vdd 0 DC 5
VBIAS qbias 0 DC 2.5
VBOOST qbias qb 0 DC 1.2
RBIAS vdd q 500k
MNQ q qb 0 0 NMOD W=10u L=1u
MPQ q qb vdd vdd PMOD W=20u L=1u
MNQB qb q 0 0 NMOD W=10u L=1u
MPQB qb q vdd vdd PMOD W=20u L=1u
MNLOAD qb vdd 0 0 NMOD W=10u L=1u
DCLAMP qb q DCLAMP AREA=1
RQ q 0 1g
RQB qb 0 1g
.ic V(q)=5 V(qb)=0
.op
.print op v(vdd) v(q) v(qb) i(VDD)
.end
