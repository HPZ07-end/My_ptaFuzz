SpiceFuzz generated DC operating-point netlist
.model NMOD NMOS LEVEL=1 VTO=0.7 KP=200u LAMBDA=0.02
.model PMOD PMOS LEVEL=1 VTO=-0.7 KP=100u LAMBDA=0.02
.model DCLAMP D IS=1e-14 N=1.05 RS=10
.subckt LATCHPAIR q qb vdd 0
MNQ q qb 0 0 NMOD W=10u L=1u
MPQ q qb vdd vdd PMOD W=20u L=1u
MNQB qb q 0 0 NMOD W=10u L=1u
MPQB qb q vdd vdd PMOD W=20u L=1u
.ends LATCHPAIR
VDD vdd 0 DC 5
RBIAS vdd q 500k
XLAT q qb vdd 0 LATCHPAIR
MNLOAD qb vdd 0 0 NMOD W=10u L=1u
MNLOAD2 qb2 vdd 0 0 NMOD W=10u L=1u
DCLAMP qb q DCLAMP AREA=1
DCLAMP2 qb2 q DCLAMP AREA=1
RQ q 0 1g
RQB qb 0 1g
RQB2 qb2 0 1.1g
.ic V(q)=5 V(qb)=0 V(qb2)=0
.op
.print op v(vdd) v(q) v(qb) v(qb2) i(VDD)
.end
