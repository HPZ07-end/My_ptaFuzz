SpiceFuzz generated DC operating-point netlist
.model NPNMOD NPN IS=1e-16 BF=200 VAF=100
.model PNPMOD PNP IS=1e-16 BF=100 VAF=80
VDD vdd 0 DC 5
VEE 0 vee DC 5
RBIAS vdd q 4.7meg
RBIASB vdd qb 4.7meg
Q1 q qb e 0 NPNMOD
Q2 qb q e 0 NPNMOD
RE e 0 1k
RC1 vdd q 10k
RC2 vdd qb 10k
RQ q 0 1g
RQB qb 0 1g
.ic V(q)=0.7 V(qb)=0 V(e)=0
.op
.print op v(vdd) v(q) v(qb) v(e) i(VDD)
.end
