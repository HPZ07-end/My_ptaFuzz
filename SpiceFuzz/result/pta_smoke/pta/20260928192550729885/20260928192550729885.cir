SpiceFuzz generated DC operating-point netlist
.model NMOD NMOS LEVEL=1 VTO=0.7 KP=200u LAMBDA=0.02
.model PMOD PMOS LEVEL=1 VTO=-0.7 KP=100u LAMBDA=0.02
.model QMOD NPN IS=1e-16 BF=200 BR=2 NF=1 NR=1 VA=80 IKF=1e-3
VDD vdd 0 DC 5
RBIAS vdd q 500k
MNQ q qb 0 0 NMOD W=10u L=1u
MPQ q qb vdd vdd PMOD W=20u L=1u
MNQB qb q 0 0 NMOD W=10u L=1u
MPQB qb q vdd vdd PMOD W=20u L=1u
MNLOAD qb vdd 0 0 NMOD W=10u L=1u
QBOOST qb q 0 QMOD AREA=1
QBOOST2 qb2 q 0 QMOD AREA=1.05
RQ q 0 1g
RQB qb 0 1g
RQB2 qb2 0 1g
RBRIDGE qb qb2 100
LBRIDGE qb qb2 1u
.ic V(q)=5 V(qb)=0 V(qb2)=0
.op
.print op v(vdd) v(q) v(qb) v(qb2) i(VDD)
.end
