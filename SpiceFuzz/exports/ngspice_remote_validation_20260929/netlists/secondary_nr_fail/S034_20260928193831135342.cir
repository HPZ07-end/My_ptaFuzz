SpiceFuzz generated DC operating-point netlist
.model DMOD D IS=2e-14 N=1.03 GMIN=1e-10
VDRV in 0 DC 1.8
RCORE1 in out 820
DCORE1 out 0 DMOD
DCORE2 0 out DMOD AREA=1.5
RCORE2 out 0 4.7k
RF001 out n002 180
RG001 n002 0 13k
RB001 n002 in 5k
RB002 n002 in 8k
RX001 n002 in 22k
RF002 out n003 180
RG002 n003 0 13k
RB003 n003 in 5k
RB004 n003 in 8k
RX002 n003 in 22k
RCORE3 out n003 4.7k
DCORE3 n003 0 DMOD
.op
.print op v(in) v(out) v(n002) v(n003) i(VDRV)
.end
