SpiceFuzz generated DC operating-point netlist
VDRV in 0 DC 2.5
RCORE1 in lmid 68
LCORE lmid out 120u
CCORE out 0 22n
RCORE2 out 0 1.8k
RF001 out n003 180
RG001 n003 0 13k
CF001 n003 0 4n
RB001 n003 in 8k
LF001 n003 l004 50u
RX001 l004 in 23k
RX002 l004 in 24k
RX003 l004 in 25k
RF002 l004 n005 316
Xmesh n005 0 in lmid out 0 meshload
.subckt meshload a b c d e f
R1 a b 4.7k
R2 d e 1.2k
C1 a f 3.3n
R3 c d 2.2k
R4 e b 6.8k
L1 d f 47u
R5 c f 9.1k
.ends meshload
.op
.print op v(in) v(out) v(lmid) i(VDRV) i(LCORE)
.end
