SpiceFuzz generated DC operating-point netlist
VDRV in 0 DC 2.5
RCORE1 in out 1.2k
RCORE2 out 0 2.7k
RF001 out n002 180
RG001 n002 0 13k
RB001 n002 in 5k
RB002 n002 in 8k
RX001 n002 in 22k
RX002 n002 in 23k
D001 n002 0 DMOD
.model DMOD D (IS=1e-14 N=1.05 RS=2)
.op
.print op v(in) v(out) i(VDRV)
.end
