SpiceFuzz generated DC operating-point netlist
VDRV in 0 DC 2.5
RCORE1 in out 1.2k
RCORE2 out 0 2.7k
RF001 out n002 180
RG001 n002 0 13k
RB001 n002 in 5k
RB002 n002 in 8k
RX001 n002 in 22k
RX002 n002 in 23k
X001 out n002 in n002 divider
.subckt divider a b c d
RD1 a b 4.7k
RD2 b c 3.3k
RD3 c d 6.8k
.ends divider
.op
.print op v(in) v(out) i(VDRV)
.end
