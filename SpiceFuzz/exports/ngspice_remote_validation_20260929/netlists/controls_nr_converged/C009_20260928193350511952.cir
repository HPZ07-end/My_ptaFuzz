SpiceFuzz generated DC operating-point netlist
VDRV in 0 DC 2.5
RCORE1 in out 1.2k
RCORE2 out 0 2.7k
RF001 out n002 180
RG001 n002 0 13k
RB001 n002 in 5k
RB002 n002 in 8k
QGAIN1 out n002 in NPNMOD
QGAIN2 out n002 in NPNMOD
QGAIN3 out n002 in NPNMOD
QGAIN4 out n002 in NPNMOD
.model NPNMOD NPN(BF=100000 IS=1e-16 VAF=100)
.op
.print op v(in) v(out) i(VDRV)
.end
