SpiceFuzz generated DC operating-point netlist
.model NMOD NMOS LEVEL=1 VTO=0.7 KP=200u LAMBDA=0.02
.model PMOD PMOS LEVEL=1 VTO=-0.7 KP=100u LAMBDA=0.02
VDD vdd 0 DC 5
RBIAS vdd q 500k
MNQ q qb 0 0 NMOD W=10u L=1u
MPQ q qb vdd vdd PMOD W=20u L=1u
MNQB qb q 0 0 NMOD W=10u L=1u
MPQB qb q vdd vdd PMOD W=20u L=1u
MNLOAD qb vdd 0 0 NMOD W=10u L=1u
RSTK1 qb n1 1meg
MSTK1 n1 n1 0 0 NMOD W=10u L=1u
RSTK2 n1 n2 1meg
MSTK2 n2 n2 0 0 NMOD W=10u L=1u
RSTK3 n2 n3 1meg
MSTK3 n3 n3 0 0 NMOD W=10u L=1u
RSTK4 n3 n4 1meg
MSTK4 n4 n4 0 0 NMOD W=10u L=1u
RSTK5 n4 0 1meg
RQ q 0 1g
RQB qb 0 1g
RASY q qb 10meg
.ic V(q)=5 V(qb)=0
.op
.print op v(vdd) v(q) v(qb) v(n1) v(n2) v(n3) v(n4) i(VDD)
.end
