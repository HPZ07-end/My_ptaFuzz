Official ngspice mos6 Level-3 process-card DC adaptation
* Origin: tests/mos6/mos6inv.cir @ c76219a
VDD vdd 0 5
VIN in 0 2.5
VSENSE vdd psource 0
MP1 out in psource vdd P12L3 L=1.2u W=5u AD=6u AS=6u PD=10u PS=10u
MN1 out in 0 0 N10L3 L=1u W=5u AD=5u AS=5u PD=10u PS=10u
RLOAD out 0 1meg
.model N10L3 NMOS
+ LEVEL=3 TPG=1 GAMMA=1.140501 THETA=0.8109787 KAPPA=0.1579183 ETA=5.0622310e-2
+ DELTA=0 UO=812.5126 VMAX=1186662 VTO=0.8
+ TOX=1.98e-8 XJ=0.2u LD=0.1u NSUB=4.9999999e16 NSS=0
+ CJ=4.091e-4 MJ=0.307 PB=1 CJSW=3.078e-10 MJSW=1e-2 CGSO=3.93e-10 CGDO=3.93e-10
.model P12L3 PMOS
+ LEVEL=3 TPG=-1 GAMMA=1.211640 THETA=0.1184638 KAPPA=0.2162577 ETA=2.7580135e-2
+ DELTA=0 UO=89.16160 VMAX=5.9e7 VTO=-0.8
+ TOX=1.98e-8 XJ=0.4u LD=0.28u NSUB=4.9999999e17 NSS=0
+ CJ=6.852e-4 MJ=0.429 PB=1 CJSW=5.217e-10 MJSW=0.351 CGSO=7.29e-10 CGDO=7.29e-10
.op
.print op v(out) v(in) i(vsense)
.end
