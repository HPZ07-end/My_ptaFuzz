TRAN level 3 case 11: diode rc stress bank
* Stress-mesh topology family adapted from PySpice rectifier, buck and relay example families; primitive-only subset: https://github.com/FabriceSalvaire/PySpice
.model DMOD D IS=2e-14 N=1.03 GMIN=1e-10
VDRV in 0 DC 2.4
RCORE1 in out 820
DCORE1 out 0 DMOD
DCORE2 0 out DMOD AREA=1.5
RCORE2 out 0 4.7k
CCORE out 0 47n
RF001 out n002 180
RG001 n002 0 13k
RB001 n002 in 5k
RB002 n002 in 8k
RX001 n002 in 22k
DF001 0 n002 DMOD AREA=3
RX002 n002 in 24k
RX003 n002 in 25k
RF002 n002 n003 316
RG002 n003 0 21k
RB003 n003 out 13k
RB004 n003 in 16k
RX004 n003 in 30k
DF002 0 n003 DMOD AREA=2
RX005 n003 in 32k
RX006 n003 in 33k
RF003 n003 n004 452
RG003 n004 0 29k
RB005 n004 n002 10k
RB006 n004 in 7k
RX007 n004 in 38k
DF003 0 n004 DMOD AREA=1
RX008 n004 in 40k
RX009 n004 in 41k
RF004 n004 n005 265
RG004 n005 0 14k
RB007 n005 n003 7k
RB008 n005 out 15k
RX010 n005 in 46k
DF004 0 n005 DMOD AREA=3
RX011 n005 in 19k
RX012 n005 in 20k
RF005 n005 n006 401
RG005 n006 0 22k
RB009 n006 n004 4k
RB010 n006 n002 6k
RX013 n006 in 25k
DF005 0 n006 DMOD AREA=2
RX014 n006 in 27k
RX015 n006 in 28k
RF006 n006 n007 214
RG006 n007 0 30k
RB011 n007 n005 12k
RB012 n007 n003 14k
RX016 n007 in 33k
DF006 0 n007 DMOD AREA=1
RX017 n007 in 35k
RX018 n007 in 36k
RF007 n007 n008 350
RG007 n008 0 15k
RB013 n008 n006 9k
RB014 n008 n004 5k
RX019 n008 in 41k
DF007 0 n008 DMOD AREA=3
RX020 n008 in 43k
RX021 n008 in 44k
RF008 n008 n009 486
RG008 n009 0 23k
RB015 n009 n007 6k
RB016 n009 n005 13k
.tran 2u 12u 0 1u UIC
.print tran time v(in) v(out) i(VDRV)
.end
