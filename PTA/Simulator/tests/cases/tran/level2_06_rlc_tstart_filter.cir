TRAN level 2 case 06: rlc tstart filter
* Stress-mesh topology family adapted from Xyce Regression RLC/filter test families; primitive-only subset: https://github.com/Xyce/Xyce_Regression
VDRV in 0 DC 3.3
RCORE1 in lmid 68
LCORE lmid out 120u
CCORE out 0 22n
RCORE2 out 0 1.8k
RF001 out n003 180
RG001 n003 0 13k
CF001 n003 0 4n
RB001 n003 in 8k
LF001 n003 l004 50u
RX001 l004 in 23k
RX002 l004 in 24k
RX003 l004 in 25k
RF002 l004 n005 316
RG002 n005 0 21k
CF002 n005 0 12n
RB002 n005 lmid 16k
LF002 n005 l006 90u
RX004 l006 in 31k
RX005 l006 in 32k
RX006 l006 in 33k
RF003 l006 n007 452
RG003 n007 0 29k
.tran 1u 12u 2u 500n UIC
.print tran time v(in) v(out) v(lmid) i(VDRV) i(LCORE)
.end
