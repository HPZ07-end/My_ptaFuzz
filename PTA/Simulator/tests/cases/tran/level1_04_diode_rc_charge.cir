TRAN level 1 case 04: diode rc charge
* Stress-mesh topology family adapted from PySpice rectifier, buck and relay example families; primitive-only subset: https://github.com/FabriceSalvaire/PySpice
.model DMOD D IS=2e-14 N=1.03 GMIN=1e-10
VDRV in 0 DC 2.4
RCORE1 in out 820
DCORE1 out 0 DMOD
DCORE2 0 out DMOD AREA=1.5
RCORE2 out 0 4.7k
CCORE out 0 47n
RF001 out n002 180
RG001 n002 0 13k
RB001 n002 in 5k
RB002 n002 in 8k
RX001 n002 in 22k
DF001 0 n002 DMOD AREA=3
RX002 n002 in 24k
.tran 1u 10u 0 1u UIC
.print tran time v(in) v(out) i(VDRV)
.end
