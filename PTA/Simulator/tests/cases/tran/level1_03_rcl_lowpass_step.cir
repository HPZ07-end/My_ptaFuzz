TRAN level 1 case 03: rcl lowpass step
* Stress-mesh topology family adapted from Qucs-S RCL ladder and LC-filter example families; primitive-only subset: https://github.com/ra3xdh/qucs_s
VDRV in 0 DC 3.3
RCORE1 in lmid 68
LCORE lmid out 120u
CCORE out 0 22n
RCORE2 out 0 1.8k
RF001 out n003 180
RG001 n003 0 13k
CF001 n003 0 4n
RB001 n003 in 8k
LF001 n003 l004 50u
RX001 l004 in 23k
.tran 1u 10u 0 1u UIC
.print tran time v(in) v(out) v(lmid) i(VDRV) i(LCORE)
.end
