TRAN level 4 case 14: rc interconnect matrix
* Stress-mesh topology family adapted from ngspice manual RC/transmission-line examples; primitive-only subset: https://ngspice.sourceforge.io/docs/ngspice-manual.pdf
VDRV in 0 DC 3.3
RCORE1 in out 1.2k
RCORE2 out 0 2.7k
CCORE out 0 12n
RF001 out n002 180
RG001 n002 0 13k
CF001 n002 0 4n
RB001 n002 in 8k
RX001 n002 in 22k
RX002 n002 in 23k
RX003 n002 in 24k
RX004 n002 in 25k
RF002 n002 n003 316
RG002 n003 0 21k
CF002 n003 0 12n
RB002 n003 in 16k
RX005 n003 in 30k
RX006 n003 in 31k
RX007 n003 in 32k
RX008 n003 in 33k
RF003 n003 n004 452
RG003 n004 0 29k
CF003 n004 0 7n
RB003 n004 in 7k
RX009 n004 in 38k
RX010 n004 in 39k
RX011 n004 in 40k
RX012 n004 in 41k
RF004 n004 n005 265
RG004 n005 0 14k
CF004 n005 0 2n
RB004 n005 out 15k
RX013 n005 in 46k
RX014 n005 in 18k
RX015 n005 in 19k
RX016 n005 in 20k
RF005 n005 n006 401
RG005 n006 0 22k
CF005 n006 0 10n
RB005 n006 n002 6k
RX017 n006 in 25k
RX018 n006 in 26k
RX019 n006 in 27k
RX020 n006 in 28k
RF006 n006 n007 214
RG006 n007 0 30k
CF006 n007 0 5n
RB006 n007 n003 14k
RX021 n007 in 33k
RX022 n007 in 34k
RX023 n007 in 35k
RX024 n007 in 36k
RF007 n007 n008 350
RG007 n008 0 15k
CF007 n008 0 13n
RB007 n008 n004 5k
RX025 n008 in 41k
RX026 n008 in 42k
RX027 n008 in 43k
RX028 n008 in 44k
RF008 n008 n009 486
RG008 n009 0 23k
CF008 n009 0 8n
RB008 n009 n005 13k
RX029 n009 in 20k
RX030 n009 in 21k
RX031 n009 in 22k
RX032 n009 in 23k
RF009 n009 n010 299
RG009 n010 0 31k
CF009 n010 0 3n
RB009 n010 n006 21k
RX033 n010 in 28k
RX034 n010 in 29k
RX035 n010 in 30k
RX036 n010 in 31k
RF010 n010 n011 435
RG010 n011 0 16k
CF010 n011 0 11n
RB010 n011 n007 12k
RX037 n011 in 36k
RX038 n011 in 37k
RX039 n011 in 38k
RX040 n011 in 39k
RF011 n011 n012 248
RG011 n012 0 24k
CF011 n012 0 6n
RB011 n012 n008 20k
RX041 n012 in 44k
RX042 n012 in 45k
RX043 n012 in 46k
RX044 n012 in 18k
RF012 n012 n013 384
RG012 n013 0 32k
CF012 n013 0 14n
RB012 n013 n009 11k
RX045 n013 in 23k
RX046 n013 in 24k
RX047 n013 in 25k
RX048 n013 in 26k
RF013 n013 n014 197
RG013 n014 0 17k
CF013 n014 0 9n
RB013 n014 n010 19k
RX049 n014 in 31k
RX050 n014 in 32k
RX051 n014 in 33k
RX052 n014 in 34k
RF014 n014 n015 333
RG014 n015 0 25k
CF014 n015 0 4n
RB014 n015 n011 10k
RX053 n015 in 39k
RX054 n015 in 40k
RX055 n015 in 41k
.tran 1u 12u 2u 500n UIC
.print tran time v(in) v(out) i(VDRV)
.end
