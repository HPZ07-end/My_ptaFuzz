TRAN level 2 case 07: diode reservoir bank
* Stress-mesh topology family adapted from PySpice rectifier, buck and relay example families; primitive-only subset: https://github.com/FabriceSalvaire/PySpice
.model DMOD D IS=2e-14 N=1.03 GMIN=1e-10
VDRV in 0 DC 2.4
RCORE1 in out 820
DCORE1 out 0 DMOD
DCORE2 0 out DMOD AREA=1.5
RCORE2 out 0 4.7k
CCORE out 0 47n
RF001 out n002 180
RG001 n002 0 13k
RB001 n002 in 5k
RB002 n002 in 8k
RX001 n002 in 22k
DF001 0 n002 DMOD AREA=3
RX002 n002 in 24k
RX003 n002 in 25k
RF002 n002 n003 316
RG002 n003 0 21k
RB003 n003 out 13k
RB004 n003 in 16k
RX004 n003 in 30k
DF002 0 n003 DMOD AREA=2
RX005 n003 in 32k
RX006 n003 in 33k
RF003 n003 n004 452
RG003 n004 0 29k
RB005 n004 n002 10k
RB006 n004 in 7k
RX007 n004 in 38k
DF003 0 n004 DMOD AREA=1
.tran 2u 12u 0 1u UIC
.print tran time v(in) v(out) i(VDRV)
.end
