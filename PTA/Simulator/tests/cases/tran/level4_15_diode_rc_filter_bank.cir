TRAN level 4 case 15: diode rc filter bank
* Stress-mesh topology family adapted from PySpice rectifier, buck and relay example families; primitive-only subset: https://github.com/FabriceSalvaire/PySpice
.model DMOD D IS=2e-14 N=1.03 GMIN=1e-10
VDRV in 0 DC 2.4
RCORE1 in out 820
DCORE1 out 0 DMOD
DCORE2 0 out DMOD AREA=1.5
RCORE2 out 0 4.7k
CCORE out 0 47n
RF001 out n002 180
RG001 n002 0 13k
RB001 n002 in 5k
RB002 n002 in 8k
RX001 n002 in 22k
DF001 0 n002 DMOD AREA=3
RX002 n002 in 24k
RX003 n002 in 25k
RF002 n002 n003 316
RG002 n003 0 21k
RB003 n003 out 13k
RB004 n003 in 16k
RX004 n003 in 30k
DF002 0 n003 DMOD AREA=2
RX005 n003 in 32k
RX006 n003 in 33k
RF003 n003 n004 452
RG003 n004 0 29k
RB005 n004 n002 10k
RB006 n004 in 7k
RX007 n004 in 38k
DF003 0 n004 DMOD AREA=1
RX008 n004 in 40k
RX009 n004 in 41k
RF004 n004 n005 265
RG004 n005 0 14k
RB007 n005 n003 7k
RB008 n005 out 15k
RX010 n005 in 46k
DF004 0 n005 DMOD AREA=3
RX011 n005 in 19k
RX012 n005 in 20k
RF005 n005 n006 401
RG005 n006 0 22k
RB009 n006 n004 4k
RB010 n006 n002 6k
RX013 n006 in 25k
DF005 0 n006 DMOD AREA=2
RX014 n006 in 27k
RX015 n006 in 28k
RF006 n006 n007 214
RG006 n007 0 30k
RB011 n007 n005 12k
RB012 n007 n003 14k
RX016 n007 in 33k
DF006 0 n007 DMOD AREA=1
RX017 n007 in 35k
RX018 n007 in 36k
RF007 n007 n008 350
RG007 n008 0 15k
RB013 n008 n006 9k
RB014 n008 n004 5k
RX019 n008 in 41k
DF007 0 n008 DMOD AREA=3
RX020 n008 in 43k
RX021 n008 in 44k
RF008 n008 n009 486
RG008 n009 0 23k
RB015 n009 n007 6k
RB016 n009 n005 13k
RX022 n009 in 20k
DF008 0 n009 DMOD AREA=2
RX023 n009 in 22k
RX024 n009 in 23k
RF009 n009 n010 299
RG009 n010 0 31k
RB017 n010 n008 3k
RB018 n010 n006 21k
RX025 n010 in 28k
DF009 0 n010 DMOD AREA=1
RX026 n010 in 30k
RX027 n010 in 31k
RF010 n010 n011 435
RG010 n011 0 16k
RB019 n011 n009 11k
RB020 n011 n007 12k
RX028 n011 in 36k
DF010 0 n011 DMOD AREA=3
RX029 n011 in 38k
RX030 n011 in 39k
RF011 n011 n012 248
RG011 n012 0 24k
RB021 n012 n010 8k
RB022 n012 n008 20k
RX031 n012 in 44k
DF011 0 n012 DMOD AREA=2
RX032 n012 in 46k
RX033 n012 in 18k
RF012 n012 n013 384
RG012 n013 0 32k
RB023 n013 n011 5k
RB024 n013 n009 11k
RX034 n013 in 23k
DF012 0 n013 DMOD AREA=1
RX035 n013 in 25k
RX036 n013 in 26k
RF013 n013 n014 197
RG013 n014 0 17k
RB025 n014 n012 13k
RB026 n014 n010 19k
RX037 n014 in 31k
DF013 0 n014 DMOD AREA=3
RX038 n014 in 33k
RX039 n014 in 34k
RF014 n014 n015 333
RG014 n015 0 25k
RB027 n015 n013 10k
RB028 n015 n011 10k
RX040 n015 in 39k
DF014 0 n015 DMOD AREA=2
RX041 n015 in 41k
RX042 n015 in 42k
RF015 n015 n016 469
RG015 n016 0 33k
RB029 n016 n014 7k
RB030 n016 n012 18k
RX043 n016 in 18k
DF015 0 n016 DMOD AREA=1
RX044 n016 in 20k
RX045 n016 in 21k
RF016 n016 n017 282
RG016 n017 0 18k
RB031 n017 n015 4k
RB032 n017 n013 9k
RX046 n017 in 26k
DF016 0 n017 DMOD AREA=3
RX047 n017 in 28k
RX048 n017 in 29k
RF017 n017 n018 418
RG017 n018 0 26k
RB033 n018 n016 12k
RB034 n018 n014 17k
RX049 n018 in 34k
DF017 0 n018 DMOD AREA=2
RX050 n018 in 36k
RX051 n018 in 37k
RF018 n018 n019 231
RG018 n019 0 34k
.tran 2u 12u 0 1u UIC
.print tran time v(in) v(out) i(VDRV)
.end
