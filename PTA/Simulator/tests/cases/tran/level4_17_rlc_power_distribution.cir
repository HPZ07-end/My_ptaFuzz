TRAN level 4 case 17: rlc power distribution
* Stress-mesh topology family adapted from Xyce Regression RLC/filter test families; primitive-only subset: https://github.com/Xyce/Xyce_Regression
VDRV in 0 DC 3.3
RCORE1 in lmid 68
LCORE lmid out 120u
CCORE out 0 22n
RCORE2 out 0 1.8k
RF001 out n003 180
RG001 n003 0 13k
CF001 n003 0 4n
RB001 n003 in 8k
LF001 n003 l004 50u
RX001 l004 in 23k
RX002 l004 in 24k
RX003 l004 in 25k
RF002 l004 n005 316
RG002 n005 0 21k
CF002 n005 0 12n
RB002 n005 lmid 16k
LF002 n005 l006 90u
RX004 l006 in 31k
RX005 l006 in 32k
RX006 l006 in 33k
RF003 l006 n007 452
RG003 n007 0 29k
CF003 n007 0 7n
RB003 n007 n003 7k
LF003 n007 l008 45u
RX007 l008 in 39k
RX008 l008 in 40k
RX009 l008 in 41k
RF004 l008 n009 265
RG004 n009 0 14k
CF004 n009 0 2n
RB004 n009 n005 15k
LF004 n009 l010 85u
RX010 l010 in 18k
RX011 l010 in 19k
RX012 l010 in 20k
RF005 l010 n011 401
RG005 n011 0 22k
CF005 n011 0 10n
RB005 n011 n007 6k
LF005 n011 l012 40u
RX013 l012 in 26k
RX014 l012 in 27k
RX015 l012 in 28k
RF006 l012 n013 214
RG006 n013 0 30k
CF006 n013 0 5n
RB006 n013 n009 14k
LF006 n013 l014 80u
RX016 l014 in 34k
RX017 l014 in 35k
RX018 l014 in 36k
RF007 l014 n015 350
RG007 n015 0 15k
CF007 n015 0 13n
RB007 n015 n011 5k
LF007 n015 l016 35u
RX019 l016 in 42k
RX020 l016 in 43k
RX021 l016 in 44k
RF008 l016 n017 486
RG008 n017 0 23k
CF008 n017 0 8n
RB008 n017 n013 13k
LF008 n017 l018 75u
RX022 l018 in 21k
RX023 l018 in 22k
RX024 l018 in 23k
RF009 l018 n019 299
RG009 n019 0 31k
CF009 n019 0 3n
RB009 n019 n015 21k
LF009 n019 l020 30u
RX025 l020 in 29k
RX026 l020 in 30k
RX027 l020 in 31k
RF010 l020 n021 435
RG010 n021 0 16k
CF010 n021 0 11n
RB010 n021 n017 12k
LF010 n021 l022 70u
RX028 l022 in 37k
RX029 l022 in 38k
RX030 l022 in 39k
RF011 l022 n023 248
RG011 n023 0 24k
CF011 n023 0 6n
RB011 n023 n019 20k
LF011 n023 l024 110u
RX031 l024 in 45k
RX032 l024 in 46k
RX033 l024 in 18k
RF012 l024 n025 384
RG012 n025 0 32k
CF012 n025 0 14n
RB012 n025 n021 11k
LF012 n025 l026 65u
RX034 l026 in 24k
RX035 l026 in 25k
RX036 l026 in 26k
RF013 l026 n027 197
RG013 n027 0 17k
CF013 n027 0 9n
RB013 n027 n023 19k
LF013 n027 l028 105u
RX037 l028 in 32k
RX038 l028 in 33k
RX039 l028 in 34k
RF014 l028 n029 333
RG014 n029 0 25k
CF014 n029 0 4n
RB014 n029 n025 10k
LF014 n029 l030 60u
RX040 l030 in 40k
RX041 l030 in 41k
RX042 l030 in 42k
RF015 l030 n031 469
RG015 n031 0 33k
CF015 n031 0 12n
RB015 n031 n027 18k
LF015 n031 l032 100u
RX043 l032 in 19k
RX044 l032 in 20k
RX045 l032 in 21k
RF016 l032 n033 282
RG016 n033 0 18k
CF016 n033 0 7n
RB016 n033 n029 9k
LF016 n033 l034 55u
RX046 l034 in 27k
RX047 l034 in 28k
RX048 l034 in 29k
RF017 l034 n035 418
RG017 n035 0 26k
CF017 n035 0 2n
RB017 n035 n031 17k
LF017 n035 l036 95u
RX049 l036 in 35k
RX050 l036 in 36k
RX051 l036 in 37k
RF018 l036 n037 231
RG018 n037 0 34k
CF018 n037 0 10n
RB018 n037 n033 8k
LF018 n037 l038 50u
RX052 l038 in 43k
RX053 l038 in 44k
RX054 l038 in 45k
RF019 l038 n039 367
RG019 n039 0 19k
CF019 n039 0 5n
RB019 n039 n035 16k
LF019 n039 l040 90u
RX055 l040 in 22k
RX056 l040 in 23k
RX057 l040 in 24k
RF020 l040 n041 180
RG020 n041 0 27k
CF020 n041 0 13n
RB020 n041 n037 7k
LF020 n041 l042 45u
RX058 l042 in 30k
RX059 l042 in 31k
RX060 l042 in 32k
RF021 l042 n043 316
RG021 n043 0 12k
CF021 n043 0 8n
RB021 n043 n039 15k
LF021 n043 l044 85u
RX061 l044 in 38k
RX062 l044 in 39k
RX063 l044 in 40k
RF022 l044 n045 452
RG022 n045 0 20k
CF022 n045 0 3n
RB022 n045 n041 6k
LF022 n045 l046 40u
RX064 l046 in 46k
RX065 l046 in 18k
RX066 l046 in 19k
RF023 l046 n047 265
RG023 n047 0 28k
CF023 n047 0 11n
RB023 n047 n043 14k
LF023 n047 l048 80u
RX067 l048 in 25k
RX068 l048 in 26k
RX069 l048 in 27k
RF024 l048 n049 401
RG024 n049 0 13k
CF024 n049 0 6n
RB024 n049 n045 5k
LF024 n049 l050 35u
RX070 l050 in 33k
RX071 l050 in 34k
RX072 l050 in 35k
RF025 l050 n051 214
RG025 n051 0 21k
CF025 n051 0 14n
RB025 n051 n047 13k
LF025 n051 l052 75u
RX073 l052 in 41k
RX074 l052 in 42k
RX075 l052 in 43k
RF026 l052 n053 350
RG026 n053 0 29k
CF026 n053 0 9n
RB026 n053 n049 21k
LF026 n053 l054 30u
RX076 l054 in 20k
RX077 l054 in 21k
RX078 l054 in 22k
RF027 l054 n055 486
RG027 n055 0 14k
CF027 n055 0 4n
RB027 n055 n051 12k
LF027 n055 l056 70u
RX079 l056 in 28k
RX080 l056 in 29k
RX081 l056 in 30k
RF028 l056 n057 299
RG028 n057 0 22k
CF028 n057 0 12n
RB028 n057 n053 20k
LF028 n057 l058 110u
RX082 l058 in 36k
RX083 l058 in 37k
RX084 l058 in 38k
RF029 l058 n059 435
RG029 n059 0 30k
CF029 n059 0 7n
RB029 n059 n055 11k
LF029 n059 l060 65u
RX085 l060 in 44k
.tran 2u 10u 0 2u UIC
.print tran time v(in) v(out) v(lmid) i(VDRV) i(LCORE)
.end
