TRAN level 2 case 05: rc op initialized ladder
* Stress-mesh topology family adapted from ngspice manual RC/transmission-line examples; primitive-only subset: https://ngspice.sourceforge.io/docs/ngspice-manual.pdf
VDRV in 0 DC 3.3
RCORE1 in out 1.2k
RCORE2 out 0 2.7k
CCORE out 0 12n
RF001 out n002 180
RG001 n002 0 13k
CF001 n002 0 4n
RB001 n002 in 8k
RX001 n002 in 22k
RX002 n002 in 23k
RX003 n002 in 24k
RX004 n002 in 25k
RF002 n002 n003 316
RG002 n003 0 21k
CF002 n003 0 12n
RB002 n003 in 16k
RX005 n003 in 30k
RX006 n003 in 31k
RX007 n003 in 32k
.tran 1u 10u 0 500n
.print tran time v(in) v(out) i(VDRV)
.end
